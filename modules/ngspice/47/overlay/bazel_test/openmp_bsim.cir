BCR OpenMP: 16 BSIM3 and 16 BSIM4 instances share a swept gate
* Distinct model instances exercise both parallel device loading loops.
Vsupply supply 0 1.8
Vgate gate 0 0
.model n3 nmos level=8 version=3.3.0 tox=10n vth0=0.5
.model n4 nmos level=14 version=4.8.3 toxe=10n vth0=0.5
.subckt pair supply gate
R3 supply drain3 10k
M3 drain3 gate 0 0 n3 l=1u w=10u ad=10p as=10p pd=22u ps=22u
R4 supply drain4 10k
M4 drain4 gate 0 0 n4 l=1u w=10u ad=10p as=10p pd=22u ps=22u
.ends pair
X01 supply gate pair
X02 supply gate pair
X03 supply gate pair
X04 supply gate pair
X05 supply gate pair
X06 supply gate pair
X07 supply gate pair
X08 supply gate pair
X09 supply gate pair
X10 supply gate pair
X11 supply gate pair
X12 supply gate pair
X13 supply gate pair
X14 supply gate pair
X15 supply gate pair
X16 supply gate pair
.control
set num_threads=@THREADS@
set wr_singlescale
set wr_vecnames
set numdgt=15
dc Vgate 0 1.8 0.05
wrdata bsim.dat i(Vsupply) v(x01.drain3) v(x01.drain4)
quit
.endc
.end
