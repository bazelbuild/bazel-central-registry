BCR XSPICE analog code model: a pulsed input amplified by three
Vinput input 0 PULSE(0 0.5 5u 0.1u 0.1u 10u 20u)
Again input output amplifier
.model amplifier gain(gain=3)
Rload output 0 1k
.control
set wr_singlescale
set wr_vecnames
set numdgt=15
tran 0.1u 40u
wrdata analog.dat v(input) v(output)
quit
.endc
.end
