BCR KLU real and complex solver: loaded RC low-pass filter
Vsource input 0 DC 10 AC 1
Rseries input output 1k
Rload output 0 1k
Cload output 0 1u
.options klu
.control
set wr_singlescale
set wr_vecnames
set numdgt=15
op
wrdata klu-op.dat v(output) i(vsource)
ac dec 4 10 100000
let output_real = real(v(output))
let output_imag = imag(v(output))
let current_real = real(i(vsource))
let current_imag = imag(i(vsource))
wrdata klu-ac.dat output_real output_imag current_real current_imag
* Reusing the circuit after AC also exercises complex-to-real KLU rebinding.
op
wrdata klu-real-again.dat v(output) i(vsource)
quit
.endc
.end
