BCR voltage divider: 10 V across equal resistors must produce 5 V
Vsource input 0 10
Rtop input output 1k
Rbottom output 0 1k
.control
version -f
set wr_singlescale
set wr_vecnames
set numdgt=15
op
wrdata divider.dat v(output)
quit
.endc
.end
