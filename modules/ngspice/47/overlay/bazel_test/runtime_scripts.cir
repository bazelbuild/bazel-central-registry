Bazel runtime script lookup
.control
echo $sourcepath
spectrum
source input_probe
quit
.endc
.end
