BCR XSPICE digital code models: ADC, inverter, and DAC
Vinput input 0 PULSE(0 1 5u 0.1u 0.1u 10u 20u)
Aadc [input] [digital_input] adc
Ainvert digital_input digital_output inverter
Adac [digital_output] [output] dac
.model adc adc_bridge(in_low=0.2 in_high=0.8)
.model inverter d_inverter(rise_delay=1n fall_delay=1n)
.model dac dac_bridge(out_low=0 out_high=1 out_undef=0.5
+ t_rise=1n t_fall=1n)
Rload output 0 1k
.control
set wr_singlescale
set wr_vecnames
set numdgt=15
tran 0.1u 40u
wrdata digital.dat v(input) v(output)
quit
.endc
.end
